procedure( tpcSystemCall( @optional (x 0) (y 0) )
  let( ( childPID childCMD result scriptName)
      scriptName=simplifyFilename("/rnda10/home/kimdy/private/SKILL/tpcAdd.pl")
      sprintf(childCMD, "%s %L %L", scriptName, x, y)
      childPID=ipcBeginProcess(childCMD)
      result = ipcReadProcess( childPID 10 )
               ipcKillProcess( childPID )
      printf("-%L-\n" result )
  )
)
; load("/rnda10/home/kimdy/private/SKILL/tpcSystemCall.il")
